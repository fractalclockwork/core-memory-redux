* driver_2x2.cir — L2 driver fidelity at n=2
* Gate: GATE-L2-E2E
* BOM path (behavioral): 74AHC138/238 → TBD62783/62083 polarity → SS14 → CCS
* Abstraction: pin-faithful decode enables + mutex — not transistor-level DMOS
* Fold: REQ-ICD-FOLD; array: 4× chan_core (same as L1)
* Sim assumption: Ic=600 mA, Ic/2=300 mA

.title GATE-L2-E2E driver 2x2

.include ../models/chan_core.lib
.include ../models/ideal_ccs.lib
.include ../models/dmos_ahc.lib

* --- 2×2 magnetic array (REQ-ICD-FOLD stand-in)
xm00 xa0_d xa0_m ya0_d ya0_m sa_m00 sa_m00n chan_core
xm10 xa0_m xa0_r ya1_d ya1_m sb_m10 sb_m10n chan_core
xm01 xa1_d xa1_m ya0_m ya0_r sb_m01 sb_m01n chan_core
xm11 xa1_m xa1_r ya1_m ya1_r sa_m11 sa_m11n chan_core
Rsa1 ya65 sa_m11 1m
Rsa2 sa_m11n sa_m00 1m
Rsa3 sa_m00n ya66 1m
Rsb1 yb65 sb_m10 1m
Rsb2 sb_m10n sb_m01 1m
Rsb3 sb_m01n yb66 1m
Rfold ya66 yb65 1m
Rsoft ya66 0 10k
Rpark_x1d xa1_d 0 100Meg
Rpark_x1r xa1_r 0 100Meg
Rpark_y1d ya1_d 0 100Meg
Rpark_y1r ya1_r 0 100Meg

* --- Decode / mutex (naming.md decode_block ABI, 2-line subset)
Bfwd_ok fwd_ok 0 V={u(0.5-V(fwd_en_n)) * u(V(rev_en_n)-0.5) * u(V(dec_en)-0.5)}
Brev_ok rev_ok 0 V={u(0.5-V(rev_en_n)) * u(V(fwd_en_n)-0.5) * u(V(dec_en)-0.5)}
Bfwd_bank fwd_bank_n 0 V={1 - V(fwd_ok)}
Brev_bank rev_bank_n 0 V={1 - V(rev_ok)}
Vaddr_xh addr_xh 0 0
Vaddr_yh addr_yh 0 0
Vaddr_x0 addr_x0 0 0
Vaddr_y0 addr_y0 0 0

xdec_x_fwd_ls addr_x0 fwd_bank_n dec_en x_fwd_ls0_en x_fwd_ls1_en ahc238_2line
xdec_x_fwd_hs addr_xh fwd_bank_n dec_en x_fwd_hs0_n x_fwd_hs1_n ahc138_2line
xdec_x_rev_ls addr_x0 rev_bank_n dec_en x_rev_ls0_en x_rev_ls1_en ahc238_2line
xdec_x_rev_hs addr_xh rev_bank_n dec_en x_rev_hs0_n x_rev_hs1_n ahc138_2line
xdec_y_fwd_ls addr_y0 fwd_bank_n dec_en y_fwd_ls0_en y_fwd_ls1_en ahc238_2line
xdec_y_fwd_hs addr_yh fwd_bank_n dec_en y_fwd_hs0_n y_fwd_hs1_n ahc138_2line
xdec_y_rev_ls addr_y0 rev_bank_n dec_en y_rev_ls0_en y_rev_ls1_en ahc238_2line
xdec_y_rev_hs addr_yh rev_bank_n dec_en y_rev_hs0_n y_rev_hs1_n ahc138_2line

Bsel_xf0 sel_x_fwd0 0 V={u(0.5-V(x_fwd_hs0_n)) * u(V(x_fwd_ls0_en)-0.5)}
Bsel_xr0 sel_x_rev0 0 V={u(0.5-V(x_rev_hs0_n)) * u(V(x_rev_ls0_en)-0.5)}
Bsel_yf0 sel_y_fwd0 0 V={u(0.5-V(y_fwd_hs0_n)) * u(V(y_fwd_ls0_en)-0.5)}
Bsel_yr0 sel_y_rev0 0 V={u(0.5-V(y_rev_hs0_n)) * u(V(y_rev_ls0_en)-0.5)}
Benx en_x 0 V={V(sel_x_fwd0) + V(sel_x_rev0)}
Beny en_y 0 V={V(sel_y_fwd0) + V(sel_y_rev0)}
Bpol pol_xy 0 V={u(V(sel_x_rev0)+V(sel_y_rev0)-0.5) - u(V(sel_x_fwd0)+V(sel_y_fwd0)-0.5)}

xsw_xd xa0_d 0 en_x ideal_drive_switch
xsw_yd ya0_d 0 en_y ideal_drive_switch
xccs_x xa0_r 0 en_x pol_xy ideal_ccs
xccs_y ya0_r 0 en_y pol_xy ideal_ccs
xss_x xa0_r xa0_rs ss14
Rss_x xa0_rs 0 1Meg
xss_y ya0_r ya0_rs ss14
Rss_y ya0_rs 0 1Meg

xsw_inh ya65 0 en_i ideal_drive_switch
xccs_i yb66 0 en_i pol_i ideal_ccs
xcmp ya65 yb66 dout tlv3501

* Standalone smoke: REV WRITE then FWD READ
Vfwd fwd_en_n 0 PWL(0 1 1.5u 1 1.55u 0 2.3u 0 2.35u 1)
Vrev rev_en_n 0 PWL(0 1 50n 1 100n 0 800n 0 850n 1)
Vdec dec_en 0 PWL(0 1)
Veni en_i 0 PWL(0 0)
Vpoli pol_i 0 PWL(0 1)

.ic v(xm00.state)=-1 v(xm01.state)=-1 v(xm10.state)=-1 v(xm11.state)=-1
.tran 5n 3u uic
.print tran v(xm00.state) v(en_x) v(dout) v(ya65,yb66)
.end
